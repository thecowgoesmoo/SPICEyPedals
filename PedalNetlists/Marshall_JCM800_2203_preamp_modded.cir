.param P_Gain_1 = 0.5
.param P_Middle = 0.5
.param P_Treble = 0.5
.param P_Volume = 0.5
.include "/workspace/SPICEyPedals/tools/../PartModels/MicroCap-LIBRARY-for-ngspice/zetex.lib"
* generated from Marshall JCM800 2203 preamp modded.schx
VCC VCC 0 DC 9
VIN IN 0 SIN(0 50m 500)
RR8 N31 N32 68k
RR9 N27 N28 10k
CC12 N3 N34 470p
RR20 0 N6 1meg
RR2 0 N9 2.7k
RR23 IN N7 33k
RR24 N10 N26 100k
RR25 0 N11 2.7k
CC13 N38 N40 2.2n
CC14 0 N9 680n
RR26 N13 N27 100k
RR27 0 N12 820
RGain_1A 0 0 {1meg * (1-P_Gain_1)}
RGain_1B 0 N31 {1meg * P_Gain_1}
CC3 N8 0 22n
CC16 N31 N44 2.2n
RR31 0 N2 470k
CC19 0 N27 22u
CC23 0 N26 22u
RR42 N26 N27 10k
RS3 0 N20 8
RMiddleA 0 N22 {25k * (1-P_Middle)}
RMiddleB N22 N23 {25k * P_Middle}
RTrebleA N18 N24 {250k * (1-P_Treble)}
RTrebleB N24 N25 {250k * P_Treble}
CC24 N16 N24 470p
CC25 N18 N21 22n
CC26 N17 N23 22n
RR44 0 N33 100k
RVolumeA 0 N20 {1meg * (1-P_Volume)}
RVolumeB N20 N25 {1meg * P_Volume}
VV8 N28 0 400
CC4 0 N36 1n
RR3 N31 N37 68k
CC7 N39 N45 2.2n
CC8 0 N12 680n
.tran 2u 100m 80m
.op
.control
  run
  quit
.endc
.end
