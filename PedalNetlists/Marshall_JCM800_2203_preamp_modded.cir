* generated from Marshall JCM800 2203 preamp modded.schx
RR8 N32 N31 68k
RR9 N28 N27 10k
CC12 N3 N34 470p
RR19 N26 N35 100k
RR20 N1 N6 1meg
RR2 N9 N1 2.7k
RR23 N7 N5 33k
RR24 N26 N10 100k
RR25 N11 N1 2.7k
CC13 N38 N40 2.2n
CC14 N9 N1 680n
RR26 N13 N27 100k
RR27 N12 N1 820
CC15 N31 N43 1n
CC3 N8 N30 22n
CC16 N44 N31 2.2n
RR31 N1 N2 470k
RR32 N3 N2 470k
VV7 N1 N5 0
CC19 N27 N15 22u
CC23 N26 N4 22u
RR42 N27 N26 10k
RS3 N20 N19 8
CC24 N24 N16 470p
CC25 N18 N21 22n
CC26 N23 N17 22n
RR43 N16 N17 33k
RR44 N33 N1 100k
VV8 N28 N29 400
RR1 N8 N35 220k
CC4 N36 N30 1n
RR3 N37 N31 68k
CC6 N39 N41 1n
CC7 N39 N45 2.2n
.tran 2u 100m 80m
.op
.control
  run
  quit
.endc
.end
