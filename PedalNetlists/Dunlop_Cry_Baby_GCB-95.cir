.param P_Filter = 0.5
* generated from Dunlop Cry Baby GCB-95.schx
VCC VCC 0 DC 9
VIN IN 0 SIN(0 50m 500)
CC1 IN N3 10n
RR1 N3 0 2.2meg
CC2 0 N8 22p
RR3 N8 N9 1.8meg
RR4 N9 VCC 1k
RR5 N11 N12 68k
CC3 N12 N13 10n
RR6 N13 N18 1.5k
RR7 0 N15 390
RR9 N18 N20 33k
RR10 N19 N20 470k
CC4 N21 0 4.7u
RR11 N20 0 82k
RR12 N19 N24 470k
CC5 N19 N25 220n
RFilterA N25 0 {100k * (1-P_Filter)}
RFilterB 0 N27 {100k * P_Filter}
CC6 N24 N27 220n
RR14 VCC N29 1k
CC7 N18 N32 10n
RS1 N25 0 8
.tran 2u 100m 80m
.op
.control
  run
  quit
.endc
.end
