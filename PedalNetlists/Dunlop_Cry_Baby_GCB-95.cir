* generated from Dunlop Cry Baby GCB-95.schx
VV1 N2 N1 0
CC1 N3 N1 10n
RR1 N3 N4 2.2meg
CC2 N5 N8 22p
RR2 N7 N6 10k
RR3 N9 N8 1.8meg
RR4 N10 N9 1k
RR5 N12 N11 68k
CC3 N13 N12 10n
RR6 N18 N13 1.5k
RR7 N14 N15 390
RR8 N17 N16 22k
RR9 N20 N18 33k
RR10 N20 N19 470k
CC4 N21 N22 4.7u
RR11 N23 N20 82k
RR12 N24 N19 470k
CC5 N19 N25 220n
CC6 N27 N24 220n
RR14 N28 N29 1k
RR15 N30 N31 10k
CC7 N32 N18 10n
RS1 N33 N25 8
.tran 2u 100m 80m
.op
.control
  run
  quit
.endc
.end
