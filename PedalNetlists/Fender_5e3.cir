* generated from Fender 5e3.schx
CC2 N3 N1 16u
RR1 N2 N3 5k
CC3 N1 N4 16u
RR4 N3 N4 22k
RR5 N9 N5 250
RR6 N13 N6 1.5k
RR7 N14 N7 1.5k
RR12 N28 N11 210
RR13 N27 N10 210
CC4 N12 N9 25u
CC5 N13 N21 100n
CC6 N25 N14 100n
RR8 N5 N14 220k
RR9 N5 N13 220k
RS1 N18 N19 8
RR15 N25 N26 56k
RR16 N20 N21 56k
RR17 N21 N22 1.5k
CC7 N24 N32 20n
RR18 N24 N23 1meg
VV3 N30 N29 0
RR14 N31 N30 1meg
RR2 N33 N31 1.5k
RR3 N34 N32 100k
RR19 N35 N30 68k
RR20 N37 N36 100k
RR21 N38 N31 1.5k
CC8 N46 N39 100n
CC9 N31 N38 25u
CC10 N43 N42 100n
RR22 N43 N31 30k
CC12 N46 N45 500p
.tran 2u 100m 80m
.op
.control
  run
  quit
.endc
.end
