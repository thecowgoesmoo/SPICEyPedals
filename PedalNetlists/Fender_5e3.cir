.param P_Volume = 0.5
.param P_Unused = 0
* generated from Fender 5e3.schx
VCC VCC 0 DC 9
VIN IN 0 SIN(0 50m 500)
CC2 0 N3 16u
RR1 N2 N3 5k
CC3 0 N4 16u
RR4 N3 N4 22k
RR5 0 N9 250
RR7 N7 N14 1.5k
RR12 N11 N28 210
RR13 N10 N27 210
CC5 0 N21 100n
CC6 N14 N25 100n
RR8 0 N14 220k
RS1 N18 0 8
RR15 N25 N26 56k
CC7 N24 N32 20n
RR18 N23 N24 1meg
RR14 IN 0 1meg
RR2 0 N33 1.5k
RR3 N32 N34 100k
RR19 IN N35 68k
RR21 0 N38 1.5k
CC8 N39 N46 100n
CC9 0 N38 25u
RVolumeA 0 N41 {1meg * (1-P_Volume)}
RVolumeB N41 N46 {1meg * P_Volume}
RUnusedA 0 N41 {1meg * (1-P_Unused)}
RUnusedB N41 N42 {1meg * P_Unused}
RR22 0 N43 30k
CC12 N45 N46 500p
.tran 2u 100m 80m
.op
.control
  run
  quit
.endc
.end
