.param P_Drive = 0.1
.param P_Level = 0.5
.include "/workspace/SPICEyPedals/tools/../PartModels/modelos_subckt/Diode_BJT_FET/GenSemi/GSdevices.lb5"
.include "/workspace/SPICEyPedals/tools/../PartModels/modelos_subckt/ti/tl072.mod"
* generated from Ibanez Tube Screamer TS-9.schx
VCC VCC 0 DC 9
VIN IN 0 SIN(0 50m 500)
RR1 VB N4 10k
CCc N5 0 51p
CCz 0 N23 47n
RR3 N5 N22 51k
RDrive 0 N22 {500k * P_Drive}
XX4 0 N15 N17 N24 TL072 ; default TL072
CC6 N15 N21 1u
RLevelA 0 0 {100k * (1-P_Level)}
RLevelB 0 N21 {100k * P_Level}
RS1 0 0 8
XX1 N4 N5 0 TL072 ; default TL072
XD1 N5 0 N8 N9 d1n4148ws
XD2 N5 0 N8 N9 d1n4148ws
.tran 2u 100m 80m
.op
.control
  run
  quit
.endc
.end
