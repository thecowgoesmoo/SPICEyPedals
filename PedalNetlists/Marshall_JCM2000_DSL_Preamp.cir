.param P_Gain = 0.5
.param P_Middle = 0.5
.param P_Treble = 0.5
.param P_Volume = 0.5
* generated from Marshall JCM2000 DSL Preamp.schx
VCC VCC 0 DC 9
VIN IN 0 SIN(0 50m 500)
RR1 N15 N19 220k
RR3 0 N13 1meg
RR4 0 N17 1.8k
RR2 IN N14 68k
CC2 0 N16 4.7n
RR6 N20 N22 100k
RR7 0 N6 1.8k
CC3 0 N20 4.7n
CC4 0 N17 4.7u
RR11 N23 N24 100k
RR12 0 N25 4.7k
RGainA 0 N3 {1meg * (1-P_Gain)}
RGainB N3 N18 {1meg * P_Gain}
RR17 0 N3 470k
CC10 N3 N44 1n
CC11 N3 N18 470p
RR5 0 N4 470k
CC1 N6 N21 1u
RR13 0 N44 47k
RR8 N3 N45 150k
RR14 0 N21 10k
CC5 0 N24 22n
RR15 0 N30 100k
RR22 0 N7 470k
CC8 0 N42 22u
RR9 N30 N42 4.7k
CC13 N30 0 10u
RR24 N23 N30 10k
CC7 0 N23 10u
RR10 N22 N23 2.7k
CC12 0 N22 10u
CC9 0 N19 10u
RR25 N19 N42 10k
RS1 0 N36 8
RMiddleA 0 N38 {20k * (1-P_Middle)}
RMiddleB N38 N39 {20k * P_Middle}
RTrebleA N34 N40 {200k * (1-P_Treble)}
RTrebleB N40 N41 {200k * P_Treble}
CC6 0 N40 220p
CC14 N34 N37 22n
CC15 N33 N39 22n
RR19 0 N29 2.2k
RVolumeA 0 N36 {1meg * (1-P_Volume)}
RVolumeB N36 N41 {1meg * P_Volume}
VV5 N42 0 400
.tran 2u 100m 80m
.op
.control
  run
  quit
.endc
.end
