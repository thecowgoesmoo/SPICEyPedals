* generated from Marshall JCM2000 DSL Preamp.schx
RR1 N15 N19 220k
RR3 N1 N13 1meg
RR4 N17 N1 1.8k
RR2 N12 N14 68k
CC2 N16 N2 4.7n
RR6 N20 N22 100k
RR7 N6 N1 1.8k
CC3 N5 N20 4.7n
CC4 N17 N1 4.7u
RR11 N23 N24 100k
RR12 N1 N25 4.7k
RR17 N2 N3 470k
CC10 N3 N44 1n
CC11 N3 N18 470p
RR5 N1 N4 470k
RR18 N4 N5 470k
CC1 N21 N6 1u
RR13 N44 N2 47k
RR14 N1 N21 10k
CC5 N8 N24 22n
RR15 N27 N30 100k
RR22 N7 N1 470k
RR23 N8 N7 470k
VV1 N12 N1 0
CC8 N32 N42 22u
RR9 N42 N30 4.7k
CC13 N30 N31 10u
RR24 N30 N23 10k
CC7 N23 N9 10u
RR10 N23 N22 2.7k
CC12 N10 N22 10u
CC9 N19 N11 10u
RR25 N42 N19 10k
RS1 N35 N36 8
CC6 N40 N27 220p
CC14 N34 N37 22n
CC15 N39 N33 22n
RR27 N33 N27 33k
RR19 N29 N1 2.2k
VV5 N43 N42 400
.tran 2u 100m 80m
.op
.control
  run
  quit
.endc
.end
