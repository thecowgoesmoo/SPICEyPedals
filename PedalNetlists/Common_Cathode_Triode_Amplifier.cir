* generated from Common Cathode Triode Amplifier.schx
VCC VCC 0 DC 9
VIN IN 0 SIN(0 50m 500)
CCi IN N3 47n
RRi N4 0 1meg
RRg N3 N6 70k
CCf N6 N11 2.5p
RRp N10 N11 100k
RRk N7 N8 1.5k
CC1 N11 N12 100n
RO1 N12 0 8
RR1 N12 0 100k
.tran 2u 100m 80m
.op
.control
  run
  quit
.endc
.end
