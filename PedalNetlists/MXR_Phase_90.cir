* generated from MXR Phase 90.schx
VV1 N1 N20 0
RR1 N2 N1 10k
CC1 N3 N2 10n
RR2 N3 N22 470k
CC2 N7 N5 47n
RR3 N6 N5 10k
RR4 N7 N8 24k
RR5 N10 N6 10k
CC3 N12 N10 47n
RR6 N11 N10 10k
RR7 N12 N8 24k
RR8 N13 N11 10k
CC4 N15 N13 47n
RR9 N14 N13 10k
RR10 N15 N8 24k
RR11 N16 N14 10k
CC5 N18 N16 47n
RR12 N17 N16 10k
RR13 N18 N8 24k
RR14 N19 N17 10k
RR15 N22 N21 10k
CC6 N24 N22 15u
RR16 N25 N9 1meg
CC7 N22 N9 47n
RR17 N9 N27 3.9meg
CC8 N27 N26 15u
RR18 N29 N28 150k
RR19 N8 N30 150k
RR20 N33 N32 470k
CC9 N32 N31 10mF
RSpeed N32 N8 470k
RR22 N35 N19 150k
RR23 N36 N35 150k
RR24 N39 N38 150k
RR25 N35 N5 150k
RR26 N37 N36 56k
CC10 N38 N36 47n
RS1 N38 N40 8
DD1 N22 N24 1N914
DD2 N24 N23 1N4733
.tran 2u 100m 80m
.op
.control
  run
  quit
.endc
.end
