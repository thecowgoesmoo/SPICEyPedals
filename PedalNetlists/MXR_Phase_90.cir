.param P_Trimmer = 0.5
.param P_Speed = 0.5
.include "/workspace/SPICEyPedals/tools/../PartModels/MicroCap-LIBRARY-for-ngspice/On_Semi.lib"
.include "/workspace/SPICEyPedals/tools/../PartModels/modelos_subckt/ti/tl072.mod"
* generated from MXR Phase 90.schx
VCC VCC 0 DC 9
VIN IN 0 SIN(0 50m 500)
RR1 IN N2 10k
CC1 N2 N3 10n
RR2 N3 N22 470k
CC2 N5 N7 47n
RR3 N5 N6 10k
RR4 N7 N8 24k
RR5 N6 N10 10k
CC3 N10 N12 47n
RR6 N10 N11 10k
RR7 N8 N12 24k
RR8 N11 N13 10k
CC4 N13 N15 47n
RR9 N13 N14 10k
RR10 N8 N15 24k
RR11 N14 N16 10k
CC5 N16 N18 47n
RR12 N16 N17 10k
RR13 N8 N18 24k
RR14 N17 N19 10k
RR15 VCC N22 10k
CC6 N22 0 15u
RTrimmerA N22 0 {250k * (1-P_Trimmer)}
RTrimmerB 0 N25 {250k * P_Trimmer}
RR16 N9 N25 1meg
CC7 N9 N22 47n
RR17 N9 N27 3.9meg
CC8 0 N27 15u
RR19 N8 N30 150k
RR20 N32 N33 470k
CC9 N31 N32 10mF
RSpeed N8 N32 {470k * P_Speed}
RR22 N19 N35 150k
RR23 N35 N36 150k
RR24 N38 0 150k
RR25 N5 N35 150k
RR26 N36 0 56k
CC10 N36 N38 47n
RS1 N38 0 8
DD1 N22 0 D1N914a
JQ2 N7 N8 N9 2N5952
JQ3 N8 N9 N12 2N5952
JQ4 N8 N9 N15 2N5952
JQ5 N8 N9 N18 2N5952
QQ1 N8 N35 N36 2N4125
DD2 N23 0 D1N4733
.tran 2u 100m 80m
.op
.control
  run
  quit
.endc
.end
