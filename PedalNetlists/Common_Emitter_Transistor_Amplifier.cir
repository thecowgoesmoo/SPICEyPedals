.include "/workspace/SPICEyPedals/tools/../PartModels/MicroCap-LIBRARY-for-ngspice/On_Semi.lib"
* generated from Common Emitter Transistor Amplifier.schx
VCC VCC 0 DC 9
VIN IN 0 SIN(0 50m 500)
CCi IN N3 47n
RRi N3 0 100k
RRe 0 N11 22
CCo N6 N9 470n
RRc N6 N7 10k
RRf N3 N6 470k
CCf N3 N6 250p
RO1 0 N9 8
RR1 N9 0 100k
QQ1 N3 N6 N11 Q2N2222 ; default 2N2222
.tran 2u 100m 80m
.op
.control
  run
  quit
.endc
.end
