* generated from Bridge Rectifier.schx
VCC VCC 0 DC 9
VIN IN 0 SIN(0 50m 500)
RR2 IN N2 100
RS1 0 N7 8
DD1 N5 0 D
DD2 N10 N11 D
DD3 N5 N9 D
DD4 N7 N8 D
.tran 2u 100m 80m
.op
.control
  run
  quit
.endc
.end
