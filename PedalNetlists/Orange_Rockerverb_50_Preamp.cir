* generated from Orange Rockerverb 50 Preamp.schx
RR9 N22 N23 10k
RR19 N21 N6 100k
RR20 N4 N1 1meg
RR2 N8 N1 1.5k
RR23 N5 N3 68k
CC1 N7 N26 1n
RR24 N21 N9 100k
RR25 N10 N1 1k
CC13 N9 N32 2.2n
CC14 N1 N8 10u
RR26 N12 N22 100k
RR27 N1 N11 2.2k
RR30 N26 N27 220k
CC16 N25 N28 100p
RR31 N33 N32 220k
VV7 N1 N3 0
CC19 N24 N22 22u
CC23 N21 N2 22u
RR42 N21 N22 10k
RS3 N16 N1 8
CC24 N20 N13 560p
CC25 N15 N17 22n
CC26 N19 N14 22n
RR43 N14 N13 39k
VV8 N23 N24 400
RR1 N1 N28 220k
CC2 N28 N29 470p
RR3 N36 N1 1.5k
RR4 N13 N35 100k
RR6 N37 N38 470k
CC7 N37 N34 4.7n
CC4 N30 N9 100p
CC6 N34 N22 100p
.tran 2u 100m 80m
.op
.control
  run
  quit
.endc
.end
