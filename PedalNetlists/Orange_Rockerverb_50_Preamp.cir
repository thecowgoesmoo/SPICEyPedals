.param P_Gain2 = 0.6
.param P_Middle = 0.5
.param P_Treble = 0.5
.param P_Volume = 0.5
.param P_Gain1 = 0.6
* generated from Orange Rockerverb 50 Preamp.schx
VCC VCC 0 DC 9
VIN IN 0 SIN(0 50m 500)
RR9 N22 N23 10k
RR19 N6 N21 100k
RR20 0 N4 1meg
RR2 0 N8 1.5k
RR23 IN N5 68k
CC1 N7 0 1n
RR24 N9 N21 100k
RR25 0 N10 1k
CC13 N9 N32 2.2n
CC14 0 N8 10u
RR27 0 N11 2.2k
RGain2A 0 N31 {1meg * (1-P_Gain2)}
RGain2B N31 N33 {1meg * P_Gain2}
RR30 0 N27 220k
CC16 N25 N28 100p
RR31 N32 N33 220k
CC19 N22 0 22u
CC23 0 N21 22u
RR42 N21 N22 10k
RS3 0 N16 8
RMiddleA 0 N18 {25k * (1-P_Middle)}
RMiddleB N18 N19 {25k * P_Middle}
RTrebleA N15 N20 {250k * (1-P_Treble)}
RTrebleB N20 N40 {250k * P_Treble}
CC24 N13 N20 560p
CC25 N15 N17 22n
CC26 N14 N19 22n
RVolumeA 0 N16 {1meg * (1-P_Volume)}
RVolumeB N16 N40 {1meg * P_Volume}
VV8 N23 0 400
RR1 0 N28 220k
CC2 N28 N29 470p
CC3 N10 N25 10u
RGain1A 0 N25 {1meg * (1-P_Gain1)}
RGain1B N25 N27 {1meg * P_Gain1}
RR3 0 N36 1.5k
RR4 N13 N35 100k
RR6 N37 N38 470k
CC7 N34 N37 4.7n
CC4 N9 N30 100p
CC6 N22 N34 100p
.tran 2u 100m 80m
.op
.control
  run
  quit
.endc
.end
