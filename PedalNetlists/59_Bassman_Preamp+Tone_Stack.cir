.param P_Treble = 0.5
.param P_Bass = 0.5
.param P_Mid = 0.5
.param P_Volume = 0.5
* generated from 59 Bassman Preamp+Tone Stack.schx
VCC VCC 0 DC 9
VIN IN 0 SIN(0 50m 500)
CC1 N1 N2 250p
CC2 N4 N6 20n
CC3 N4 N7 20n
RR1 N1 N4 56k
RTrebleA N2 N6 {250k * (1-P_Treble)}
RTrebleB N6 N8 {250k * P_Treble}
RBass N5 N6 {1meg * P_Bass}
RMidA 0 N5 {25k * (1-P_Mid)}
RMidB N5 N7 {25k * P_Mid}
RS1 N8 0 8
RR2 IN 0 1meg
RR3 IN N13 68k
RR4 N14 N15 820
CC4 N14 N15 250u
RR5 N17 N19 100k
RVolumeA 0 N20 {1meg * (1-P_Volume)}
RVolumeB N20 N21 {1meg * P_Volume}
CC5 N17 N20 20n
RR7 N21 N22 270k
CC6 N21 N30 100p
RR8 N23 0 820
RR9 N25 N26 100k
.tran 2u 100m 80m
.op
.control
  run
  quit
.endc
.end
