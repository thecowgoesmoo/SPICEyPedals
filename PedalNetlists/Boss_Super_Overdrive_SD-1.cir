.param P_Drive = 0.5
.param P_Level = 0.5
.include "/workspace/SPICEyPedals/tools/../PartModels/MicroCap-LIBRARY-for-ngspice/On_Semi.lib"
.include "/workspace/SPICEyPedals/tools/../PartModels/modelos_subckt/ti/tl072.mod"
* generated from Boss Super Overdrive SD-1.schx
VCC VCC 0 DC 9
VIN IN 0 SIN(0 50m 500)
CCc N3 0 47p
CCz 0 N20 47n
RR2 N3 N20 4.7k
RR3 N3 N18 33k
RDrive 0 N18 {1meg * P_Drive}
XX4 0 N11 N13 N21 N27 N28 TL072 ; default TL072
CC6 N11 N17 1u
RLevelA 0 0 {10k * (1-P_Level)}
RLevelB 0 N26 {10k * P_Level}
RS1 0 0 8
RR10 N17 N26 4.7k
XX1 N3 0 N19 TL072 ; default TL072
XD1 N3 0 N29 1N916
DD2 N3 N29 1N916
DD3 0 N29 1N916
.tran 2u 100m 80m
.op
.control
  run
  quit
.endc
.end
