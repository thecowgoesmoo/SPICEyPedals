.param P_Rs1 = 0.5
* generated from Wien Bridge Oscillator.schx
VCC VCC 0 DC 9
VIN IN 0 SIN(0 50m 500)
RR1 N1 N2 1.49k
CC1 N1 N3 100n
RR2 N4 N5 1.49k
CC2 N5 N6 100n
RRf N6 N7 22k
RRs1 N7 N10 {800 * P_Rs1}
RRs2 N10 0 10.5k
VV3 N1 0 0.01] V
RS1 N6 0 8
.tran 2u 100m 80m
.op
.control
  run
  quit
.endc
.end
