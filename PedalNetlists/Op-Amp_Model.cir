* generated from Op-Amp Model.schx
VCC VCC 0 DC 9
VIN IN 0 SIN(0 50m 500)
RR1 N2 0 100
RR2 N6 N7 10k
DD1 N1 N10 D
DD2 N1 N11 D
RS1 N7 0 8
VV6 N9 N10 2
VV7 N11 N12 2
RRp1 N1 0 1k
CCp1 N1 0 159u
RRout N7 N14 100
RRin N2 IN 1meg
.tran 2u 100m 80m
.op
.control
  run
  quit
.endc
.end
