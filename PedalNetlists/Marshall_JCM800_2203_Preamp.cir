* generated from Marshall JCM800 2203 Preamp.schx
RR8 N34 N11 68k
RR9 N29 N30 10k
CC12 N38 N3 470p
RR19 N28 N8 100k
RR20 N1 N6 1meg
RR2 N10 N1 2.7k
RR23 N7 N5 68k
CC1 N9 N32 22n
RR24 N28 N12 100k
RR25 N13 N1 10k
CC13 N12 N3 22n
CC14 N10 N1 680n
RR26 N15 N29 100k
RR27 N1 N14 820
RR30 N32 N35 470k
CC15 N36 N33 470p
CC16 N36 N11 1n
RR31 N1 N2 470k
RR32 N3 N2 470k
RR33 N33 N32 47k
VV7 N1 N5 0
CC19 N17 N29 22u
CC23 N28 N4 22u
RR42 N28 N29 10k
RS3 N22 N21 8
CC24 N26 N18 470p
CC25 N20 N23 22n
CC26 N25 N19 22n
RR43 N19 N18 33k
RR44 N1 N37 100k
VV8 N30 N31 400
.tran 2u 100m 80m
.op
.control
  run
  quit
.endc
.end
