.param P_Gain = 0.5
.param P_Middle = 0.5
.param P_Treble = 0.5
.param P_Volume = 0.5
* generated from Marshall JCM800 2203 Preamp.schx
VCC VCC 0 DC 9
VIN IN 0 SIN(0 50m 500)
RR8 N11 N34 68k
RR9 N29 N30 10k
CC12 N3 N38 470p
RR19 N8 N28 100k
RR20 0 N6 1meg
RR2 0 N10 2.7k
RR23 IN N7 68k
CC1 N9 0 22n
RR24 N12 N28 100k
RR25 0 N13 10k
CC13 N3 N12 22n
CC14 0 N10 680n
RR26 N15 N29 100k
RR27 0 N14 820
RGainA 0 N11 {1meg * (1-P_Gain)}
RGainB N11 N35 {1meg * P_Gain}
RR30 0 N35 470k
CC15 N33 N36 470p
CC16 N11 N36 1n
RR31 0 N2 470k
RR33 0 N33 47k
CC19 0 N29 22u
CC23 0 N28 22u
RR42 N28 N29 10k
RS3 0 N22 8
RMiddleA 0 N24 {25k * (1-P_Middle)}
RMiddleB N24 N25 {25k * P_Middle}
RTrebleA N20 N26 {250k * (1-P_Treble)}
RTrebleB N26 N27 {250k * P_Treble}
CC24 N18 N26 470p
CC25 N20 N23 22n
CC26 N19 N25 22n
RR44 0 N37 100k
RVolumeA 0 N22 {1meg * (1-P_Volume)}
RVolumeB N22 N27 {1meg * P_Volume}
VV8 N30 0 400
.tran 2u 100m 80m
.op
.control
  run
  quit
.endc
.end
