* generated from Marshall Blues Breaker.schx
VV1 N27 N1 0
RR1 N6 N2 1meg
CC1 N6 N17 10n
RR2 N5 N3 33k
CC2 N3 N4 10n
CC3 N7 N4 10n
RR3 N5 N4 27k
CC4 N8 N5 100p
CC5 N10 N9 100n
RR4 N11 N10 10k
RR5 N11 N25 6.8k
RR6 N14 N11 220k
RS1 N16 N30 8
RR8 N17 N18 2.2meg
CC8 N23 N15 100n
RR7 N14 N24 1k
CC6 N20 N19 10n
CC7 N20 N22 10n
RR9 N21 N22 6.8k
DD1 N25 N12 1N4148
DD2 N14 N12 1N4148
DD3 N14 N26 1N4148
DD4 N26 N25 1N4148
.tran 2u 100m 80m
.op
.control
  run
  quit
.endc
.end
