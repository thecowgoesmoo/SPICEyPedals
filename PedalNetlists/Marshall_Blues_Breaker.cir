.param P_Drive = 0.6
.param P_Tone = 0.8
.param P_Level = 0.5
.include "/workspace/SPICEyPedals/tools/../PartModels/modelos_subckt/Diode_BJT_FET/GenSemi/GSdevices.lb5"
* generated from Marshall Blues Breaker.schx
VCC VCC 0 DC 9
VIN IN 0 SIN(0 50m 500)
RR1 VB N6 1meg
CC1 N6 VB 10n
CC2 N3 N4 10n
CC3 N4 VB 10n
RR3 N4 N5 27k
CC4 N5 N8 100p
RDriveA N5 N8 {100k * (1-P_Drive)}
RDriveB N8 N9 {100k * P_Drive}
CC5 N9 N10 100n
RR4 N10 N11 10k
RR5 N11 N25 6.8k
RR6 N11 N14 220k
RS1 0 N30 8
RR8 VB 0 2.2meg
CC8 N15 N23 100n
RR7 N14 N24 1k
RToneA N19 N21 {25k * (1-P_Tone)}
RToneB N21 N24 {25k * P_Tone}
CC6 N19 VB 10n
CC7 VB N22 10n
RR9 N21 N22 6.8k
RLevelA VB N22 {100k * (1-P_Level)}
RLevelB N22 N23 {100k * P_Level}
DD1 N12 N25 d1n4148ws
DD2 N12 N14 d1n4148ws
DD3 N14 N26 d1n4148ws
DD4 N25 N26 d1n4148ws
.tran 2u 100m 80m
.op
.control
  run
  quit
.endc
.end
