* generated from Big Muff Pi.schx
VV1 N2 N1 0
RR1 N1 N48 39k
CC1 N4 N48 1u
RR2 N4 N3 47k
RR3 N6 N5 100
RR4 N7 N8 470k
CC2 N4 N8 470p
RR5 N8 N9 10k
CC3 N12 N8 1u
RR6 N11 N10 1k
CC4 N14 N13 100n
RR7 N16 N14 10k
RR8 N15 N16 100k
RR9 N18 N17 150
CC5 N19 N16 470p
RR10 N19 N16 470k
DD1 N19 N20 1N914
DD2 N19 N21 1N914
CC6 N16 N20 1u
RR11 N22 N19 10k
RR12 N31 N24 10k
RR13 N23 N24 100k
RR14 N26 N25 150
CC8 N27 N24 470p
RR15 N24 N27 470k
DD3 N27 N28 1N914
DD4 N27 N29 1N914
CC9 N28 N24 1u
RR16 N27 N30 10k
CC7 N31 N19 100n
CC10 N32 N33 10n
RR17 N27 N33 39k
CC11 N27 N34 4n
RR18 N35 N34 22k
CC12 N38 N36 100u
RR19 N37 N38 100k
RR20 N38 N41 430k
RR21 N40 N39 3.3k
RR22 N41 N42 15k
CC13 N43 N44 100n
RS1 N46 N47 8
.tran 2u 100m 80m
.op
.control
  run
  quit
.endc
.end
