.param P_Sustain = 0.5
.param P_Tone = 0.5
.param P_Volume = 0.5
.include "/workspace/SPICEyPedals/tools/../PartModels/MicroCap-LIBRARY-for-ngspice/On_Semi.lib"
* generated from Big Muff Pi.schx
VCC VCC 0 DC 9
VIN IN 0 SIN(0 50m 500)
RR1 IN N48 39k
CC1 N4 N48 1u
RR2 0 N4 47k
QQ1 N4 N6 N8 BC239C
RR3 0 N6 100
RR4 N7 N8 470k
CC2 N4 N8 470p
RR5 N8 VCC 10k
CC3 N8 N12 1u
RR6 0 N11 1k
RSustainA N11 N12 {100k * (1-P_Sustain)}
RSustainB N12 N13 {100k * P_Sustain}
CC4 N13 N14 100n
RR7 N14 N16 10k
RR8 0 N16 100k
QQ2 N16 N17 N19 BC239C
RR9 N17 0 150
CC5 N16 N19 470p
RR10 N16 N19 470k
DD1 N19 N20 D1N914a
DD2 N19 N21 D1N914a
RR11 N19 VCC 10k
RR12 N24 N31 10k
RR13 0 N24 100k
QQ3 N24 N25 N27 BC239C
RR14 N25 0 150
CC8 N24 N27 470p
RR15 N24 N27 470k
DD3 N27 N28 D1N914a
DD4 N27 N29 D1N914a
RR16 N27 VCC 10k
CC7 N19 N31 100n
CC10 0 N33 10n
RR17 N27 N33 39k
CC11 N27 N34 4n
RToneA N33 N34 {100k * (1-P_Tone)}
RToneB N34 N36 {100k * P_Tone}
RR18 N34 0 22k
CC12 N36 N38 100u
RR19 0 N38 100k
RR20 N38 VCC 430k
QQ4 N38 N40 N42 BC239C
RR21 0 N40 3.3k
CC13 N43 N44 100n
RVolumeA N44 0 {100k * (1-P_Volume)}
RVolumeB 0 N47 {100k * P_Volume}
RS1 0 N47 8
.tran 2u 100m 80m
.op
.control
  run
  quit
.endc
.end
